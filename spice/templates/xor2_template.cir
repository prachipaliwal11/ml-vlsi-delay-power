* CMOS 2-Input XOR Gate (XOR2, 12-transistor static CMOS) using sky130 PDK

.include "{model_path}"

.temp {temp}

Vsupply vdd 0 DC {vdd}
{vin_a_line}
{vin_b_line}

* Local inverters to generate complements a_bar, b_bar
XINVA_P a_bar a vdd vdd sky130_fd_pr__pfet_01v8 W={width_inv} L=0.15
XINVA_N a_bar a 0 0 sky130_fd_pr__nfet_01v8 W={width_inv} L=0.15
XINVB_P b_bar b vdd vdd sky130_fd_pr__pfet_01v8 W={width_inv} L=0.15
XINVB_N b_bar b 0 0 sky130_fd_pr__nfet_01v8 W={width_inv} L=0.15

* Pull-up network (PMOS): Y=1 when A!=B -- parallel branches (a_bar,b) and (a,b_bar), each series
XP1 p1 a_bar vdd vdd sky130_fd_pr__pfet_01v8 W={width_p1} L=0.15
XP2 out b p1 vdd sky130_fd_pr__pfet_01v8 W={width_p2} L=0.15
XP3 p2 a vdd vdd sky130_fd_pr__pfet_01v8 W={width_p3} L=0.15
XP4 out b_bar p2 vdd sky130_fd_pr__pfet_01v8 W={width_p4} L=0.15

* Pull-down network (NMOS): Y=0 when A=B -- parallel branches (a,b) and (a_bar,b_bar), each series
XN1 out a n1 0 sky130_fd_pr__nfet_01v8 W={width_n1} L=0.15
XN2 n1 b 0 0 sky130_fd_pr__nfet_01v8 W={width_n2} L=0.15
XN3 out a_bar n2 0 sky130_fd_pr__nfet_01v8 W={width_n3} L=0.15
XN4 n2 b_bar 0 0 sky130_fd_pr__nfet_01v8 W={width_n4} L=0.15

Cload out 0 {cload}f

.tran 0.01n 20n
.control
run
wrdata {output_file} v(a) v(b) v(out) i(vsupply)
.endc
.end
