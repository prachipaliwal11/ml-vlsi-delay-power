* CMOS Inverter using sky130 PDK

.include "{model_path}"

.temp {temp}

Vsupply vdd 0 DC {vdd}
Vin in 0 PULSE(0 {vdd} 1n 0.1n 0.1n 5n 10n)

XM1 out in vdd vdd sky130_fd_pr__pfet_01v8 W={width_p} L=0.15
XM2 out in 0 0 sky130_fd_pr__nfet_01v8 W={width_n} L=0.15

Cload out 0 {cload}f

.tran 0.01n 20n
.control
run
wrdata {output_file} v(in) v(out) i(vsupply)
.endc
.end
