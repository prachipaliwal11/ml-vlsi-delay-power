* CMOS Inverter using sky130 PDK

.lib "/home/prachi/pdk/volare/sky130/versions/c6d73a35f524070e85faff4a6a9eef49553ebc2b/sky130A/libs.tech/ngspice/sky130.lib.spice" tt

Vdd vdd 0 DC 1.8
Vin in 0 PULSE(0 1.8 1n 0.1n 0.1n 5n 10n)

XM1 out in vdd vdd sky130_fd_pr__pfet_01v8 W=1 L=0.15
XM2 out in 0 0 sky130_fd_pr__nfet_01v8 W=0.5 L=0.15

Cload out 0 5f

.tran 0.01n 20n
.control
run
wrdata inverter_output.txt v(in) v(out)
.endc
.end
